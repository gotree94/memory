.SUBCKT SDRAM_ARRAY_8X8 WL0 WL1 WL2 WL3 WL4 WL5 WL6 WL7 BL0 BL1 BL2 BL3 BL4 BL5 BL6 BL7 PLATE VSS
* 8x8 array of DRAM1T1C cells
X00 BL0 WL0 PLATE VSS DRAM1T1C
X01 BL1 WL0 PLATE VSS DRAM1T1C
X02 BL2 WL0 PLATE VSS DRAM1T1C
X03 BL3 WL0 PLATE VSS DRAM1T1C
X04 BL4 WL0 PLATE VSS DRAM1T1C
X05 BL5 WL0 PLATE VSS DRAM1T1C
X06 BL6 WL0 PLATE VSS DRAM1T1C
X07 BL7 WL0 PLATE VSS DRAM1T1C
X10 BL0 WL1 PLATE VSS DRAM1T1C
X11 BL1 WL1 PLATE VSS DRAM1T1C
X12 BL2 WL1 PLATE VSS DRAM1T1C
X13 BL3 WL1 PLATE VSS DRAM1T1C
X14 BL4 WL1 PLATE VSS DRAM1T1C
X15 BL5 WL1 PLATE VSS DRAM1T1C
X16 BL6 WL1 PLATE VSS DRAM1T1C
X17 BL7 WL1 PLATE VSS DRAM1T1C
X20 BL0 WL2 PLATE VSS DRAM1T1C
X21 BL1 WL2 PLATE VSS DRAM1T1C
X22 BL2 WL2 PLATE VSS DRAM1T1C
X23 BL3 WL2 PLATE VSS DRAM1T1C
X24 BL4 WL2 PLATE VSS DRAM1T1C
X25 BL5 WL2 PLATE VSS DRAM1T1C
X26 BL6 WL2 PLATE VSS DRAM1T1C
X27 BL7 WL2 PLATE VSS DRAM1T1C
X30 BL0 WL3 PLATE VSS DRAM1T1C
X31 BL1 WL3 PLATE VSS DRAM1T1C
X32 BL2 WL3 PLATE VSS DRAM1T1C
X33 BL3 WL3 PLATE VSS DRAM1T1C
X34 BL4 WL3 PLATE VSS DRAM1T1C
X35 BL5 WL3 PLATE VSS DRAM1T1C
X36 BL6 WL3 PLATE VSS DRAM1T1C
X37 BL7 WL3 PLATE VSS DRAM1T1C
X40 BL0 WL4 PLATE VSS DRAM1T1C
X41 BL1 WL4 PLATE VSS DRAM1T1C
X42 BL2 WL4 PLATE VSS DRAM1T1C
X43 BL3 WL4 PLATE VSS DRAM1T1C
X44 BL4 WL4 PLATE VSS DRAM1T1C
X45 BL5 WL4 PLATE VSS DRAM1T1C
X46 BL6 WL4 PLATE VSS DRAM1T1C
X47 BL7 WL4 PLATE VSS DRAM1T1C
X50 BL0 WL5 PLATE VSS DRAM1T1C
X51 BL1 WL5 PLATE VSS DRAM1T1C
X52 BL2 WL5 PLATE VSS DRAM1T1C
X53 BL3 WL5 PLATE VSS DRAM1T1C
X54 BL4 WL5 PLATE VSS DRAM1T1C
X55 BL5 WL5 PLATE VSS DRAM1T1C
X56 BL6 WL5 PLATE VSS DRAM1T1C
X57 BL7 WL5 PLATE VSS DRAM1T1C
X60 BL0 WL6 PLATE VSS DRAM1T1C
X61 BL1 WL6 PLATE VSS DRAM1T1C
X62 BL2 WL6 PLATE VSS DRAM1T1C
X63 BL3 WL6 PLATE VSS DRAM1T1C
X64 BL4 WL6 PLATE VSS DRAM1T1C
X65 BL5 WL6 PLATE VSS DRAM1T1C
X66 BL6 WL6 PLATE VSS DRAM1T1C
X67 BL7 WL6 PLATE VSS DRAM1T1C
X70 BL0 WL7 PLATE VSS DRAM1T1C
X71 BL1 WL7 PLATE VSS DRAM1T1C
X72 BL2 WL7 PLATE VSS DRAM1T1C
X73 BL3 WL7 PLATE VSS DRAM1T1C
X74 BL4 WL7 PLATE VSS DRAM1T1C
X75 BL5 WL7 PLATE VSS DRAM1T1C
X76 BL6 WL7 PLATE VSS DRAM1T1C
X77 BL7 WL7 PLATE VSS DRAM1T1C
.ENDS
