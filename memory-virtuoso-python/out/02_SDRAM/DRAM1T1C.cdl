.SUBCKT DRAM1T1C BL WL PLATE VSS
* 1T1C DRAM cell; C0 is an ideal educational storage capacitor
M0 BL WL SN VSS g45n1svt w=0.18u l=0.045u nf=1 m=1
C0 SN PLATE 10f
.ENDS
