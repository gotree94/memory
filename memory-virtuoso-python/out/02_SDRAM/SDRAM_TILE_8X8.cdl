.SUBCKT SDRAM_TILE_8X8 WL0 WL1 WL2 WL3 WL4 WL5 WL6 WL7 BL0 BL1 BL2 BL3 BL4 BL5 BL6 BL7 BLB0 BLB1 BLB2 BLB3 BLB4 BLB5 BLB6 BLB7 PRE SAE VBL PLATE VDD VSS
* 8x8 SDRAM-style tile with precharge and sense amplifiers
XARR WL0 WL1 WL2 WL3 WL4 WL5 WL6 WL7 BL0 BL1 BL2 BL3 BL4 BL5 BL6 BL7 PLATE VSS SDRAM_ARRAY_8X8
XPC0 BL0 BLB0 PRE VBL VDD DRAM_PRECHARGE
XPC1 BL1 BLB1 PRE VBL VDD DRAM_PRECHARGE
XPC2 BL2 BLB2 PRE VBL VDD DRAM_PRECHARGE
XPC3 BL3 BLB3 PRE VBL VDD DRAM_PRECHARGE
XPC4 BL4 BLB4 PRE VBL VDD DRAM_PRECHARGE
XPC5 BL5 BLB5 PRE VBL VDD DRAM_PRECHARGE
XPC6 BL6 BLB6 PRE VBL VDD DRAM_PRECHARGE
XPC7 BL7 BLB7 PRE VBL VDD DRAM_PRECHARGE
XSA0 BL0 BLB0 SAE VDD VSS DRAM_SENSE
XSA1 BL1 BLB1 SAE VDD VSS DRAM_SENSE
XSA2 BL2 BLB2 SAE VDD VSS DRAM_SENSE
XSA3 BL3 BLB3 SAE VDD VSS DRAM_SENSE
XSA4 BL4 BLB4 SAE VDD VSS DRAM_SENSE
XSA5 BL5 BLB5 SAE VDD VSS DRAM_SENSE
XSA6 BL6 BLB6 SAE VDD VSS DRAM_SENSE
XSA7 BL7 BLB7 SAE VDD VSS DRAM_SENSE
.ENDS
