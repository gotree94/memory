.SUBCKT GDDR6_TILE_4X4 WL0 WL1 WL2 WL3 BL0 BL1 BL2 BL3 BLB0 BLB1 BLB2 BLB3 DQ0 DQ1 DQ2 DQ3 PRE SAE VBL PLATE VDD VSS
* 4x4 GDDR6-style read tile (simplified)
XARR WL0 WL1 WL2 WL3 BL0 BL1 BL2 BL3 PLATE VSS GDDR6_ARRAY_4X4
XPC0 BL0 BLB0 PRE VBL VDD GDDR6_PRECHARGE
XPC1 BL1 BLB1 PRE VBL VDD GDDR6_PRECHARGE
XPC2 BL2 BLB2 PRE VBL VDD GDDR6_PRECHARGE
XPC3 BL3 BLB3 PRE VBL VDD GDDR6_PRECHARGE
XSA0 BL0 BLB0 SAE VDD VSS GDDR6_SENSE
XSA1 BL1 BLB1 SAE VDD VSS GDDR6_SENSE
XSA2 BL2 BLB2 SAE VDD VSS GDDR6_SENSE
XSA3 BL3 BLB3 SAE VDD VSS GDDR6_SENSE
XIO0 BL0 DQ0 VDD VSS GDDR6_IO
XIO1 BL1 DQ1 VDD VSS GDDR6_IO
XIO2 BL2 DQ2 VDD VSS GDDR6_IO
XIO3 BL3 DQ3 VDD VSS GDDR6_IO
.ENDS
