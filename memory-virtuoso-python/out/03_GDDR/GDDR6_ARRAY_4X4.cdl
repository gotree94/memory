.SUBCKT GDDR6_ARRAY_4X4 WL0 WL1 WL2 WL3 BL0 BL1 BL2 BL3 PLATE VSS
* 4x4 array of GDDR6_CELL
X00 BL0 WL0 PLATE VSS GDDR6_CELL
X01 BL1 WL0 PLATE VSS GDDR6_CELL
X02 BL2 WL0 PLATE VSS GDDR6_CELL
X03 BL3 WL0 PLATE VSS GDDR6_CELL
X10 BL0 WL1 PLATE VSS GDDR6_CELL
X11 BL1 WL1 PLATE VSS GDDR6_CELL
X12 BL2 WL1 PLATE VSS GDDR6_CELL
X13 BL3 WL1 PLATE VSS GDDR6_CELL
X20 BL0 WL2 PLATE VSS GDDR6_CELL
X21 BL1 WL2 PLATE VSS GDDR6_CELL
X22 BL2 WL2 PLATE VSS GDDR6_CELL
X23 BL3 WL2 PLATE VSS GDDR6_CELL
X30 BL0 WL3 PLATE VSS GDDR6_CELL
X31 BL1 WL3 PLATE VSS GDDR6_CELL
X32 BL2 WL3 PLATE VSS GDDR6_CELL
X33 BL3 WL3 PLATE VSS GDDR6_CELL
.ENDS
