.SUBCKT SRAM_ARRAY_8X8 WL0 WL1 WL2 WL3 WL4 WL5 WL6 WL7 BL0 BL1 BL2 BL3 BL4 BL5 BL6 BL7 BLB0 BLB1 BLB2 BLB3 BLB4 BLB5 BLB6 BLB7 VDD VSS
* 8x8 array of SRAM6T bitcells
X00 BL0 BLB0 WL0 VDD VSS SRAM6T
X01 BL1 BLB1 WL0 VDD VSS SRAM6T
X02 BL2 BLB2 WL0 VDD VSS SRAM6T
X03 BL3 BLB3 WL0 VDD VSS SRAM6T
X04 BL4 BLB4 WL0 VDD VSS SRAM6T
X05 BL5 BLB5 WL0 VDD VSS SRAM6T
X06 BL6 BLB6 WL0 VDD VSS SRAM6T
X07 BL7 BLB7 WL0 VDD VSS SRAM6T
X10 BL0 BLB0 WL1 VDD VSS SRAM6T
X11 BL1 BLB1 WL1 VDD VSS SRAM6T
X12 BL2 BLB2 WL1 VDD VSS SRAM6T
X13 BL3 BLB3 WL1 VDD VSS SRAM6T
X14 BL4 BLB4 WL1 VDD VSS SRAM6T
X15 BL5 BLB5 WL1 VDD VSS SRAM6T
X16 BL6 BLB6 WL1 VDD VSS SRAM6T
X17 BL7 BLB7 WL1 VDD VSS SRAM6T
X20 BL0 BLB0 WL2 VDD VSS SRAM6T
X21 BL1 BLB1 WL2 VDD VSS SRAM6T
X22 BL2 BLB2 WL2 VDD VSS SRAM6T
X23 BL3 BLB3 WL2 VDD VSS SRAM6T
X24 BL4 BLB4 WL2 VDD VSS SRAM6T
X25 BL5 BLB5 WL2 VDD VSS SRAM6T
X26 BL6 BLB6 WL2 VDD VSS SRAM6T
X27 BL7 BLB7 WL2 VDD VSS SRAM6T
X30 BL0 BLB0 WL3 VDD VSS SRAM6T
X31 BL1 BLB1 WL3 VDD VSS SRAM6T
X32 BL2 BLB2 WL3 VDD VSS SRAM6T
X33 BL3 BLB3 WL3 VDD VSS SRAM6T
X34 BL4 BLB4 WL3 VDD VSS SRAM6T
X35 BL5 BLB5 WL3 VDD VSS SRAM6T
X36 BL6 BLB6 WL3 VDD VSS SRAM6T
X37 BL7 BLB7 WL3 VDD VSS SRAM6T
X40 BL0 BLB0 WL4 VDD VSS SRAM6T
X41 BL1 BLB1 WL4 VDD VSS SRAM6T
X42 BL2 BLB2 WL4 VDD VSS SRAM6T
X43 BL3 BLB3 WL4 VDD VSS SRAM6T
X44 BL4 BLB4 WL4 VDD VSS SRAM6T
X45 BL5 BLB5 WL4 VDD VSS SRAM6T
X46 BL6 BLB6 WL4 VDD VSS SRAM6T
X47 BL7 BLB7 WL4 VDD VSS SRAM6T
X50 BL0 BLB0 WL5 VDD VSS SRAM6T
X51 BL1 BLB1 WL5 VDD VSS SRAM6T
X52 BL2 BLB2 WL5 VDD VSS SRAM6T
X53 BL3 BLB3 WL5 VDD VSS SRAM6T
X54 BL4 BLB4 WL5 VDD VSS SRAM6T
X55 BL5 BLB5 WL5 VDD VSS SRAM6T
X56 BL6 BLB6 WL5 VDD VSS SRAM6T
X57 BL7 BLB7 WL5 VDD VSS SRAM6T
X60 BL0 BLB0 WL6 VDD VSS SRAM6T
X61 BL1 BLB1 WL6 VDD VSS SRAM6T
X62 BL2 BLB2 WL6 VDD VSS SRAM6T
X63 BL3 BLB3 WL6 VDD VSS SRAM6T
X64 BL4 BLB4 WL6 VDD VSS SRAM6T
X65 BL5 BLB5 WL6 VDD VSS SRAM6T
X66 BL6 BLB6 WL6 VDD VSS SRAM6T
X67 BL7 BLB7 WL6 VDD VSS SRAM6T
X70 BL0 BLB0 WL7 VDD VSS SRAM6T
X71 BL1 BLB1 WL7 VDD VSS SRAM6T
X72 BL2 BLB2 WL7 VDD VSS SRAM6T
X73 BL3 BLB3 WL7 VDD VSS SRAM6T
X74 BL4 BLB4 WL7 VDD VSS SRAM6T
X75 BL5 BLB5 WL7 VDD VSS SRAM6T
X76 BL6 BLB6 WL7 VDD VSS SRAM6T
X77 BL7 BLB7 WL7 VDD VSS SRAM6T
.ENDS
