.SUBCKT HBM3_TILE_4X4 WL0 WL1 WL2 WL3 BL0 BL1 BL2 BL3 BLB0 BLB1 BLB2 BLB3 DQ0 DQ1 DQ2 DQ3 PRE SAE VBL PLATE VDD VSS
* 4x4 HBM3-style tile with TSV models (simplified)
XARR WL0 WL1 WL2 WL3 BL0 BL1 BL2 BL3 PLATE VSS HBM3_ARRAY_4X4
XPC0 BL0 BLB0 PRE VBL VDD HBM3_PRECHARGE
XPC1 BL1 BLB1 PRE VBL VDD HBM3_PRECHARGE
XPC2 BL2 BLB2 PRE VBL VDD HBM3_PRECHARGE
XPC3 BL3 BLB3 PRE VBL VDD HBM3_PRECHARGE
XSA0 BL0 BLB0 SAE VDD VSS HBM3_SENSE
XSA1 BL1 BLB1 SAE VDD VSS HBM3_SENSE
XSA2 BL2 BLB2 SAE VDD VSS HBM3_SENSE
XSA3 BL3 BLB3 SAE VDD VSS HBM3_SENSE
XIO0 BL0 TSVIN0 VDD VSS HBM3_IO
XIO1 BL1 TSVIN1 VDD VSS HBM3_IO
XIO2 BL2 TSVIN2 VDD VSS HBM3_IO
XIO3 BL3 TSVIN3 VDD VSS HBM3_IO
XTSV0 TSVIN0 DQ0 VSS HBM3_TSV
XTSV1 TSVIN1 DQ1 VSS HBM3_TSV
XTSV2 TSVIN2 DQ2 VSS HBM3_TSV
XTSV3 TSVIN3 DQ3 VSS HBM3_TSV
.ENDS
