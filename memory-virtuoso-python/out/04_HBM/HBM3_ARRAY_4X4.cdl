.SUBCKT HBM3_ARRAY_4X4 WL0 WL1 WL2 WL3 BL0 BL1 BL2 BL3 PLATE VSS
* 4x4 array of HBM3_CELL
X00 BL0 WL0 PLATE VSS HBM3_CELL
X01 BL1 WL0 PLATE VSS HBM3_CELL
X02 BL2 WL0 PLATE VSS HBM3_CELL
X03 BL3 WL0 PLATE VSS HBM3_CELL
X10 BL0 WL1 PLATE VSS HBM3_CELL
X11 BL1 WL1 PLATE VSS HBM3_CELL
X12 BL2 WL1 PLATE VSS HBM3_CELL
X13 BL3 WL1 PLATE VSS HBM3_CELL
X20 BL0 WL2 PLATE VSS HBM3_CELL
X21 BL1 WL2 PLATE VSS HBM3_CELL
X22 BL2 WL2 PLATE VSS HBM3_CELL
X23 BL3 WL2 PLATE VSS HBM3_CELL
X30 BL0 WL3 PLATE VSS HBM3_CELL
X31 BL1 WL3 PLATE VSS HBM3_CELL
X32 BL2 WL3 PLATE VSS HBM3_CELL
X33 BL3 WL3 PLATE VSS HBM3_CELL
.ENDS
