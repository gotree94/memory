; =============================================================================
; Cadence 45nm GPDK 학습 라이브러리 통합 초기화 (공용)
; Cadence 45nm Learning-PDK Unified Initializer
;
; 대상 라이브러리 (C:\\Users\\Administrator\\Desktop\\memory 아래 설치됨):
;   1. GPDK045/giolib045_v3.3   -> OA 라이브러리 "giolib045"  (IO/PAD 셀)
;   2. gsclib045_all_v4.8/GSCLIB045 -> OA 라이브러리 "gsclib045" (표준 셀)
;
; 사용:
;   load("flow/skill/cad45_init.skill")
;   cad45LibsEnabled()
; =============================================================================

; -------------------------------------------------------------------------
; 1. 경로/라이브러리 상수
; -------------------------------------------------------------------------
defvar(cad45_root        "C:/Users/Administrator/Desktop/memory")
; NOTE: dbOpenLib 경로는 OA 라이브러리 루트(셀 디렉토리를 포함한 폴더)를 가리켜야 한다.
;       설치 매뉴얼/버전에 따라 "GSCLIB045" 또는 "GSCLIB045/oa22/gsclib045" 일 수 있으므로,
;       Virtuoso에서 열리지 않으면 아래 경로를 한 단계 상위로 조정 (attachTech 참고).
defvar(cad45_giolib_oa   strcat(cad45_root "/GPDK045/giolib045_v3.3/oa22/giolib045"))
defvar(cad45_giolib_lef  strcat(cad45_root "/GPDK045/giolib045_v3.3/lef/giolib045.lef"))
defvar(cad45_giolib_cdl  strcat(cad45_root "/GPDK045/giolib045_v3.3/cdl/giolib045.cdl"))
defvar(cad45_gsclib_oa   strcat(cad45_root "/gsclib045_all_v4.8/GSCLIB045/oa22/gsclib045"))

defvar(cad45_giolib_name "giolib045")   ; OA 라이브러리 이름 (PAD)
defvar(cad45_gsclib_name "gsclib045")   ; OA 라이브러리 이름 (표준 셀)
defvar(cad45_tech_name   "gpdk045")     ; 참조 기술 (CDL 디바이스 네이밍 기준)

; -------------------------------------------------------------------------
; 2. GPDK045 디바이스 모델명 (cdl/giolib045.cdl 에서 확인됨)
;    g45p1svt / g45n1svt : 1.0V swing, 표준 Vt
;    g45p2svt / g45n2svt : 2.5V swing (IO 트랜지스터)
; -------------------------------------------------------------------------
defvar(cad45_devices   list("g45p1svt" "g45n1svt" "g45p2svt" "g45n2svt"))
defvar(cad45_dev_core  list("g45p1svt" "g45n1svt"))
defvar(cad45_dev_io    list("g45p2svt" "g45n2svt"))

; -------------------------------------------------------------------------
; 3. gsclib045 표준 셀 인벤토리 (oa22/gsclib045 실제 셀 목록)
; -------------------------------------------------------------------------
defvar(cad45_cells
  list("ADDFHXL" "ADDFX1" "AND2XL" "AND3XL" "AO21XL" "AOI211X4" "AOI21X2"
       "AOI222X4" "AOI22X1" "AOI22X2" "AOI31X4" "AOI32X2" "AOI33X1" "AOI33X2"
       "BUFX20" "BUFX6" "CLKMX2X8" "CLKXOR2X4" "DFFHQX1" "DFFHQX2" "DFFQXL"
       "DFFSRXL" "DLY1X4" "DLY2X4" "DLY4X1" "EDFFTRX1" "FILL64" "FSWX1"
       "INVXL" "LSLH_ISONH_X1_TO_ON" "MX2X1" "MX2X2" "MX3X1" "MXI2X1"
       "NAND2X8" "NAND4X6" "NOR2BX1" "NOR2BX2" "NOR2X4" "NOR3BX2" "NOR3X2"
       "NOR4BBX1" "NOR4BX4" "NOR4X1" "NOR4X2" "OA21X4" "OAI22XL"
       "OAI2BB1X4" "OAI2BB2X4" "OAI33XL" "OR4X8" "RDFFNQX1" "RDFFNRX1"
       "RDFFNSRQX1" "SDFF4RX2" "SDFFNSRXL" "SDFFQX4" "SDFFRX2" "SDFFSRHQX8"
       "SDFFSX1" "SDFFX4" "SEDFFHQX4" "SEDFFX1" "SPDFF4RX1" "TBUFX6"
       "TLATNCAX2" "TLATNSRX1" "TLATSRX2" "XNOR2XL"))

; -------------------------------------------------------------------------
; 4. giolib045 IO/PAD 셀 인벤토리
;    NOTE: OA(oa22)에 실제 셀뷰로 존재하는 PAD만 placement 가능.
;    일부 PAD(PADDI/PADDO/PADDB 등)는 CDL 넷리스트/LEF에만 존재한다.
; -------------------------------------------------------------------------
; 4a. OA 셀뷰로 존재 (dbOpenCellViewByType 으로 instantiate 가능)
defvar(cad45_pads_oa
  list("bidirlogic" "ESDCore04_Input" "ESDCoreNMArray" "ESDCorePM"
       "IORINGDI" "IORINGFEED3X" "IORINGFEED60" "IORINGVSS" "IORINGVSS25"
       "nonzoutlogic" "PADVDD" "PADVDD25" "PADVDDIOR"))
; 4b. CDL/LEF에만 존재 (OA 셀뷰 없음 -> instancing 불가, LVS/CDL 참조용)
defvar(cad45_pads_cdl
  list("BONDPAD52" "PADANALOG" "PADDB" "PADDI" "PADDO" "PADDOZ"
       "PADVSS" "PADVSS25" "PADVSSIOR"))
; 4c. 호환용 통합 목록
defvar(cad45_pads append(cad45_pads_oa cad45_pads_cdl))

; -------------------------------------------------------------------------
; 5. 초기화 헬퍼
; -------------------------------------------------------------------------
procedure(cad45LibsEnabled @optional (quiet nil)
  let((libs ok)
    ; gsclib045 (표준 셀)
    libs = nil
    if(!dbIsOpen(cad45_gsclib_name) then
      libs = dbOpenLib(cad45_gsclib_oa "r")
      if(libs then
        unless(quiet printf("cad45: opened %s (standard cells)\\n" cad45_gsclib_name)
        )
      else
        printf("cad45: WARNING - cannot open %s at %s\\n" cad45_gsclib_name cad45_gsclib_oa)
      )
    )
    ; giolib045 (IO/PAD)
    if(!dbIsOpen(cad45_giolib_name) then
      libs = dbOpenLib(cad45_giolib_oa "r")
      if(libs then
        unless(quiet printf("cad45: opened %s (IO pads)\\n" cad45_giolib_name)
        )
      else
        printf("cad45: WARNING - cannot open %s at %s\\n" cad45_giolib_name cad45_giolib_oa)
      )
    )
    if(dbIsOpen(cad45_gsclib_name) && dbIsOpen(cad45_giolib_name) then t else nil)
  )
)

; 새 메모리 라이브러리를 45nm 기술에 붙이는 헬퍼.
; (실 환경에서는 CIW File > New > Library 후 attach techfile을 압니다.)
procedure(cad45AttachTech(libName @optional (techName cad45_tech_name))
  let(()
    printf("cad45: attach library '%s' to tech '%s'\\n" libName techName)
    ; Virtuoso에서: techInit / cdsAttachTech 사용 가능
    printf("cad45:   => Tech File not executed here (run inside Virtuoso).\\n")
    t
  )
)

; gsclib045 표준 셀/ giolib045 PAD 존재 확인 (OA 셀뷰 기준)
procedure(cad45CellExists(cellName @optional (libName cad45_gsclib_name))
  let((lib)
    lib = ddGetObj(libName)
    if(lib && dbOpenCellViewByType(libName cellName "layout" "" "r")
       then t else nil)
  )
)

; -------------------------------------------------------------------------
; 데모 출력 (로드 시)
; -------------------------------------------------------------------------
printf("cad45_init loaded: gsclib045 (%d cells) + giolib045 "
       "(%d OA pads / %d CDL-only pads)\\n"
       length(cad45_cells) length(cad45_pads_oa) length(cad45_pads_cdl))
