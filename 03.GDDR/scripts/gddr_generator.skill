; ============================================================
; GDDR Memory Generator for Virtuoso
; GDDR5 / GDDR6 / GDDR6X 어레이 및 I/O 회로 자동 생성
; ============================================================
; Cadence 45nm 학습 PDK 연동:
;   load("flow/skill/cad45_init.skill")
;   load("flow/skill/cad45_periph.skill")   ; PAD 매핑: PADDB/PADDOZ/PADDI
;   load("gddr_generator.skill")
;   gddrCreateArray("gddr_lib" "gddr6x_array" "GDDR6X" 16 4 16)
; ============================================================
when(ignoreError(cad45LibsEnabled(nil)) != t,
    printf("gddr: WARNING - cad45_init.skill not loaded, "
        "run load(\"flow/skill/cad45_init.skill\") first\\n")
)

; ============================================================
; 공통 헬퍼
; ============================================================

procedure(gddrCommon(libName cellName viewName)
    let((cv)
        when(geCreateCell(nil libName cellName viewName "layout" "layout"),
            printf("Created: %s/%s/%s\\n" libName cellName viewName))
        cv = dbOpenCellViewByType(libName cellName viewName "" "a")
        when(nil == cv,
            printf("Error: Cannot open cell view %s\\n" cellName)
            return(nil))
        return(cv)
    )
endprocedure

; ============================================================
; 1. GDDR 셀 어레이 생성 (SINGLE 32-bit)
; ============================================================

procedure(gddrCreateArray(
    libName
    cellName
    generation    ; "GDDR5", "GDDR6", "GDDR6X"
    numBanks
    bankGroups
    bitsPerChannel
)
    let((cv ws tech
          chipW chipH
          channelW channelH
          bankW bankH
          bgW bgH
          i j ch bg
          dqRowX)

        ; ========================================
        ; 세대별 칩 / 채널 파라미터
        ; ========================================
        when(generation == "GDDR5",
            chipW = 14.0;  chipH = 8.0    ; mm
            channelW = 14.0; channelH = 8.0
            numCh = 1
        )
        when(generation == "GDDR6",
            chipW = 16.0;  chipH = 9.0
            channelW = 7.5; channelH = 9.0
            numCh = 2   ; Dual 16-bit 서브채널
        )
        when(generation == "GDDR6X",
            chipW = 16.0;  chipH = 9.0
            channelW = 7.5; channelH = 9.0
            numCh = 2
        )

        cv = gddrCommon(libName cellName "layout")
        when(nil == cv, return(nil))

        ; ========================================
        ; 셀 어레이 및 뱅크 그룹 레이아웃
        ; ========================================
        printf("[%s] Generating cell array view...\\n" generation)
        printf("  Chip Size: %.1f x %.1f mm\\n" chipW chipH)
        printf("  Channels: %d\\n" numCh)
        printf("  Banks: %d, Bank Groups: %d\\n" numBanks bankGroups)

        ; 채널 영역 배치
        for(ch 0 numCh-1,
            chX = ch * (channelW + 0.5)
            dbCreateRect(cv list("M1" "drawing")
                list(chX 0.0 (+ chX channelW) channelH))
            dbCreateText(cv sprintf(nil "Ch_%d" ch)
                list(+ chX 0.5) 0.5 "M1" 0.5 "centerCenter")

            ; 채널 내 뱅크 그룹 분할
            bgW = channelW / bankGroups
            for(bg 0 bankGroups-1,
                bgX = chX + bg * bgW
                dbCreateRect(cv list("M2" "drawing")
                    list(bgX 1.0 (+ bgX bgW) (- channelH 2.0)))
                dbCreateText(cv sprintf(nil "BG%02d" bg)
                    list(+ bgX 0.3) (+ channelH 2.5) "M2" 0.3 "centerCenter")
            )

            ; DQ 데이터 패드
            for(i 0 bitsPerChannel-1,
                dqX = chX + 1.0 + i * 0.6
                dbCreateRect(cv list("M3" "drawing")
                    list(dqX (- 0.5) (+ dqX 0.5) 0.5))
                dbCreateText(cv sprintf(nil "DQ%02d" i)
                    list(+ dqX 0.3) 0.5 "M3" 0.2 "centerCenter")
            )
        )

        ; DQS / WCK 클럭 영역
        dbCreateText(cv "DQS0" list(0.5 (- 1.2)) "M2" 0.3 "centerCenter")
        dbCreateText(cv "WCK0" list(2.0 (- 1.2)) "M2" 0.3 "centerCenter")
        when(generation == "GDDR6" || generation == "GDDR6X",
            dbCreateText(cv "DQS1" list(9.0 (- 1.2)) "M2" 0.3 "centerCenter")
            dbCreateText(cv "WCK1" list(10.5 (- 1.2)) "M2" 0.3 "centerCenter")
        )

        ; ========================================
        ; 시그널링 레이블
        ; ========================================
        when(generation == "GDDR6X",
            ; PAM4 레벨 표시
            dbCreateText(cv "PAM4" list(0.5 (+ channelH 1.0))
                "M3" 0.4 "centerCenter")
            dbCreateText(cv "L0:L3" list(0.5 (+ channelH 1.6))
                "M3" 0.2 "centerCenter")
        )
        when(generation == "GDDR5",
            dbCreateText(cv "NRZ" list(0.5 (+ channelH 1.0))
                "M3" 0.4 "centerCenter")
        )

        dbSave(cv)
        printf("[%s] Array generation complete\\n" generation)
    )
endprocedure

; ============================================================
; 2. GDDR I/O 트렌시버 회로 생성 (NRZ)
; ============================================================

procedure(gddrCreateIOCircuit(
    libName
    ioCellName
    generation    ; "GDDR5", "GDDR6"
)
    let((cv)

        cv = gddrCommon(libName ioCellName "schematic")
        when(nil == cv, return(nil))

        printf("[%s] Generating NRZ I/O transceiver...\\n" generation)

        ; NRZ 평문식 TX/RX 스케마틱 구조
        ; ── TX: DATA ──> [Driver] ──> TX_OUT
        ; ── RX: RX_IN ──> [Receiver] ──> DATA_OUT

        ; 스케마틱 생성은 회로도 셀로 처리
        dbCreateText(cv "DATA" list(1.0 5.0) "M1" 0.3 "centerCenter")
        dbCreateText(cv "TX" list(3.0 5.0) "M1" 0.3 "centerCenter")
        dbCreateText(cv "TX_OUT" list(5.0 5.0) "M1" 0.3 "centerCenter")
        dbCreateText(cv "RX_IN" list(5.0 3.0) "M1" 0.3 "centerCenter")
        dbCreateText(cv "RX" list(3.0 3.0) "M1" 0.3 "centerCenter")
        dbCreateText(cv "DOUT" list(1.0 3.0) "M1" 0.3 "centerCenter")

        dbSave(cv)
        printf("[%s] NRZ I/O circuit generated\\n" generation)
    )
endprocedure

; ============================================================
; 3. PAM4 트렌시버 회로 생성 (GDDR6X)
; ============================================================

procedure(gddrCreatePAM4IO(
    libName
    ioCellName
)
    let((cv)

        cv = gddrCommon(libName ioCellName "schematic")
        when(nil == cv, return(nil))

        printf("[GDDR6X] Generating PAM4 I/O transceiver...\\n")

        ; PAM4 4-레벨 신호 생성
        ; MSB/LSB → TX → PAM4 출력
        ; RX → 슬라이서 → MSB/LSB 복원

        ; TX 블록
        dbCreateInst(cv "pam4_encoder" "PAM4_ENC" list(2.0 5.0) "R0")
        dbCreateInst(cv "tx_pad" "TX_PAD" list(4.0 5.0) "R0")

        ; RX 블록 (3개 슬라이서: VREF1/2/3 비교)
        dbCreateInst(cv "rx_pad" "RX_PAD" list(4.0 3.0) "R0")
        dbCreateInst(cv "slicer1" "SL1" list(3.0 2.0) "R0")
        dbCreateInst(cv "slicer2" "SL2" list(3.0 1.5) "R0")
        dbCreateInst(cv "slicer3" "SL3" list(3.0 1.0) "R0")
        dbCreateInst(cv "decoder" "PAM4_DEC" list(2.0 2.0) "R0")

        ; 레벨 세그먼트
        dbCreateText(cv "MSB" list(1.0 6.0) "M1" 0.2 "centerCenter")
        dbCreateText(cv "LSB" list(1.0 5.5) "M1" 0.2 "centerCenter")
        dbCreateText(cv "PAM4_TX" list(5.0 5.0) "M2" 0.2 "centerCenter")
        dbCreateText(cv "PAM4_RX" list(5.0 3.0) "M2" 0.2 "centerCenter")

        ; 레퍼런스 전압
        dbCreateText(cv "VREF1" list(5.5 2.2) "M3" 0.1 "centerCenter")
        dbCreateText(cv "VREF2" list(5.5 1.7) "M3" 0.1 "centerCenter")
        dbCreateText(cv "VREF3" list(5.5 1.2) "M3" 0.1 "centerCenter")

        dbSave(cv)
        printf("[GDDR6X] PAM4 I/O circuit generated\\n")
    )
endprocedure

; ============================================================
; 4. GDDR 듀얼 채널 분리 (GDDR6/GDDR6X)
; ============================================================

procedure(gddrCreateDualChannel(
    libName
    cellName
    bitsPerChannel   ; 16
)
    let((cv i)

        cv = gddrCommon(libName cellName "layout")
        when(nil == cv, return(nil))

        printf("Generating dual independent channel (2x%d-bit)...\\n" bitsPerChannel)

        ; Channel A (좌측) / Channel B (우측) 분리
        ; 각 채널에 독립된 커맨드/어드레스/데이터 버스
        for(i 0 1,
            chX = i * 8.0   ; 채널 간 물리적 0.5mm 간격 포함

            dbCreateRect(cv list("M1" "drawing")
                list(chX 0.0 (+ chX 7.5) 9.0))
            dbCreateText(cv sprintf(nil "CH%c" (+ 65 i))
                list(+ chX 0.5) 8.0 "M1" 0.4 "centerCenter")

            ; 독립 DQ 16-bit
            for(j 0 bitsPerChannel-1,
                dqX = chX + 1.0 + j * 0.4
                dbCreateText(cv sprintf(nil "%c_DQ%02d" (+ 65 i) j)
                    list(dqX (- 0.5)) "M2" 0.15 "centerCenter")
            )

            ; 독립 커맨드/어드레스
            dbCreateText(cv sprintf(nil "%c_CMD" (+ 65 i))
                list(+ chX 0.5) 1.0 "M2" 0.2 "centerCenter")
            dbCreateText(cv sprintf(nil "%c_ADDR" (+ 65 i))
                list(+ chX 0.5) 1.5 "M2" 0.2 "centerCenter")
        )

        ; 채널 분리 벽 (아이솔레이션)
        dbCreatePath(cv list(7.75 0.0 7.75 9.0) "M4" 0.1)

        dbSave(cv)
        printf("Dual channel layout generated\\n")
    )
endprocedure

; ============================================================
; 5. 클럭 트리 생성 (WCK/CK)
; ============================================================

procedure(gddrCreateClockTree(
    libName
    cellName
    numPLL
    numWCK
)
    let((cv i)

        cv = gddrCommon(libName cellName "layout")
        when(nil == cv, return(nil))

        printf("Generating WCK/CK clock distribution...\\n")

        ; PLL 배치
        for(i 0 numPLL-1,
            dbCreateRect(cv list("M1" "drawing")
                list((* i 4.0) 2.0 (+ (* i 4.0) 3.0) 5.0))
            dbCreateText(cv sprintf(nil "PLL%02d" i)
                list((* i 4.0) 1.0) "M2" 0.3 "centerCenter")
        )

        ; WCK 차동 클럭 버퍼
        for(i 0 numWCK-1,
            wckX = i * 2.5
            dbCreateText(cv sprintf(nil "WCK%d/WCK#%d" i i)
                list(wckX 7.0) "M3" 0.2 "centerCenter")
        )

        dbSave(cv)
        printf("Clock tree generated\\n")
    )
endprocedure

; ============================================================
; 사용 예제
; ============================================================
; Virtuoso CIW에서 실행:
;
; 1. GDDR5 어레이:
;    gddrCreateArray("gddr_lib" "gddr5_array" "GDDR5" 16 4 32)
;
; 2. GDDR6 듀얼 채널:
;    gddrCreateArray("gddr_lib" "gddr6_array" "GDDR6" 16 4 16)
;    gddrCreateDualChannel("gddr_lib" "gddr6_channels" 16)
;
; 3. GDDR6X PAM4 I/O:
;    gddrCreatePAM4IO("gddr_lib" "gddr6x_pam4_io")
;
; 4. GDDR6 NRZ I/O:
;    gddrCreateIOCircuit("gddr_lib" "gddr6_io" "GDDR6")
;
; 5. 클럭 트리:
;    gddrCreateClockTree("gddr_lib" "gddr_clock" 2 4)
;

println("GDDR Memory Generator loaded successfully")
println("Usage:")
println("  gddrCreateArray(libName cellName generation numBanks bankGroups bits/ch)")
println("  gddrCreateDualChannel(libName cellName bitsPerChannel)")
println("  gddrCreatePAM4IO(libName cellName)")
println("  gddrCreateIOCircuit(libName cellName generation)")
println("  gddrCreateClockTree(libName cellName numPLL numWCK)")
