; ============================================================
; GDDR Memory Generator
; Library: gddr_lib
; Cell:    gddr_gddr6x_io_driver
; View:    layout
; Auto-generated by GDDR Design Automation Tool
; ============================================================

procedure(gddrCreategddr_gddr6x_io_driver()
    let((cv ws tech
          chipW chipH
          chSel chOffset
          i))

        ; ========================================
        ; GDDR6X PAM4 TX Driver
        ; ========================================

        ; PAM4 레벨: 00, 01, 10, 11 (4 levels)
        ; 눈(Eye) 마진: 70mV (레벨 간격)
        ; 출력 스윙: 0.5V

        ; ── PAM4 Transmitter 회로 구성 ──
        ;   MSB ──> [Upper Driver] ─┐
        ;                            ├──> TX_OUT (4레벨 출력)
        ;   LSB ──> [Lower Driver] ─┘
        ;
        ;   00 = V00 (0V)
        ;   01 = V01 (Vswing/3)
        ;   10 = V10 (2*Vswing/3)
        ;   11 = V11 (Vswing)

        ; MSB/LSB 디코더
        dbCreateInst(cv "pam4_encoder" "PAM4_ENC" list(2.0 8.0) "R0")
        dbCreateInst(cv "driver_hi" "DRV_HI" list(4.0 6.0) "R0")
        dbCreateInst(cv "driver_lo" "DRV_LO" list(4.0 4.0) "R0")
        dbCreateInst(cv "tx_pad" "TX_PAD" list(6.0 5.0) "R0")

        ; 신호 배선 (이상적 라벨 연결)
        dbCreateText(cv "MSB" list(1.0 8.0) "M1" 0.2 "centerCenter")
        dbCreateText(cv "LSB" list(1.0 7.0) "M1" 0.2 "centerCenter")
        dbCreateText(cv "TX_OUT" list(7.0 5.0) "M2" 0.2 "centerCenter")
        dbCreateText(cv "VDDQ" list(3.0 9.0) "M1" 0.2 "centerCenter")

        ; PAM4 레벨 레퍼런스
        dbCreateText(cv "VREF1" list(8.0 9.0) "M3" 0.1 "centerCenter")
        dbCreateText(cv "VREF2" list(8.0 8.0) "M3" 0.1 "centerCenter")
        dbCreateText(cv "VREF3" list(8.0 7.0) "M3" 0.1 "centerCenter")

        ; WCK 차동 데이터 클럭 수신
        dbCreateInst(cv "wck_receiver" "WCK_RX" list(2.0 2.0) "R0")
        dbCreateText(cv "WCK" list(1.0 2.0) "M3" 0.2 "centerCenter")
        dbCreateText(cv "WCK#" list(1.0 1.0) "M3" 0.2 "centerCenter")

        when(cv,
            dbSave(cv)
            println("GDDR I/O driver generated")
        )
    )
endprocedure
