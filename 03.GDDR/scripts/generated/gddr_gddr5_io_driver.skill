; ============================================================
; GDDR Memory Generator
; Library: gddr_lib
; Cell:    gddr_gddr5_io_driver
; View:    layout
; Auto-generated by GDDR Design Automation Tool
; ============================================================

procedure(gddrCreategddr_gddr5_io_driver()
    let((cv ws tech
          chipW chipH
          chSel chOffset
          i))

        ; ========================================
        ; GDDR5 NRZ TX Driver
        ; ========================================

        ; NRZ 레벨: 0, 1 (2 levels)
        ; 눈 마진: 150mV
        ; 출력 스윙: 0.8V

        ; ── NRZ Transmitter 회로 구성 ──
        ;   DATA ──> [Driver] ──> TX_OUT (2레벨 출력)
        ;
        ;   0 = V00 (0V)
        ;   1 = V11 (Vswing)

        dbCreateInst(cv "driver" "DRV" list(3.0 6.0) "R0")
        dbCreateInst(cv "tx_pad" "TX_PAD" list(5.0 6.0) "R0")

        dbCreateText(cv "DATA" list(1.0 6.0) "M1" 0.2 "centerCenter")
        dbCreateText(cv "TX_OUT" list(6.0 6.0) "M2" 0.2 "centerCenter")
        dbCreateText(cv "VDDQ" list(3.0 7.0) "M1" 0.2 "centerCenter")

        ; WCK 차동 데이터 클럭 수신
        dbCreateInst(cv "wck_receiver" "WCK_RX" list(2.0 2.0) "R0")
        dbCreateText(cv "WCK" list(1.0 2.0) "M3" 0.2 "centerCenter")
        dbCreateText(cv "WCK#" list(1.0 1.0) "M3" 0.2 "centerCenter")

        when(cv,
            dbSave(cv)
            println("GDDR I/O driver generated")
        )
    )
endprocedure
