; ============================================================
; GDDR Memory Generator
; Library: gddr_lib
; Cell:    gddr_gddr6x_array
; View:    layout
; Auto-generated by GDDR Design Automation Tool
; ============================================================

procedure(gddrCreategddr_gddr6x_array()
    let((cv ws tech
          chipW chipH
          chSel chOffset
          i))

        ; ========================================
        ; GDDR6X - GDDR6X 9nm
        ; ========================================
        ; 채널 구조: dual_16bit_pam4
        ; 시그널링: pam4
        ; 데이터 레이트: 21.0 Gbps/pin
        ; 대역폭: 1000 GB/s
        ; I/O 전원: VDDQ = 1.35V
        ; 칩 크기: 16.0mm x 9.0mm
        ; 패키징: BGA (180-ball)

        ; 체널 / 뱅크 그룹 분할
        ; ┌─────────────────────────────┐
        ; │   BankGroup 0   BankGroup 1 │
        ; │   ┌─────┐      ┌─────┐      │
        ; │   │  0  │      │  2  │      │
        ; │   └─────┘      └─────┘      │
        ; │   ┌─────┐      ┌─────┐      │
        ; │   │  1  │      │  3  │      │
        ; │   └─────┘      └─────┘      │
        ; └─────────────┴─────────────┘

        ; 뱅크 그룹 수: 4
        ; 뱅크 수: 16
        ; 채널 수: 2

        ; 채널 A 배치 (좌측)
        chOffset = 0.0
        for(i 0 (2-1)
            dbCreateRect(cv list("M1" "drawing")
                list(chOffset 0.0 (+ chOffset 8.0) 9.0)
            )
            dbCreateText(cv sprintf(nil "Channel_%c" (+ 65 i))
                list(+ chOffset 0.5) 1.0
                "M1" 0.5 "centerCenter")
            chOffset = chOffset + 8.0 + 0.5   ; 채널 간 간격
        )

        ; 뱅크 그룹 배치
        bgWidth = 8.0 / 4
        for(i 0 (4-1)
            dbCreateText(cv sprintf(nil "BankGroup_%d" i)
                list(+ (* bgWidth i) 1.0) 8.0
                "M2" 0.3 "centerCenter")
        )

        ; 데이터 핀 배치 (DQS 영역)
        dbCreateText(cv "DQS"
            list(1.0 6.0) "M3" 0.3 "centerCenter")
        dbCreateText(cv "WCLK"
            list(3.0 6.0) "M3" 0.3 "centerCenter")
        dbCreateText(cv "CK/CK#"
            list(5.0 6.0) "M3" 0.3 "centerCenter")

        when(cv,
            dbSave(cv)
            println("GDDR array layout generated")
        )
    )
endprocedure
