; ============================================================
; HBM 3D Stack Generator
; Library: hbm_lib
; Cell:    hbm_hbm3e_base_die
; Auto-generated by HBM Design Automation Tool
; ============================================================

procedure(hbmCreatehbm_hbm3e_base_die()
    let((cv ws tech
          dieW dieH dieTh
          tsvR tsvPitch tsvCols tsvRows
          chSel chX
          i j k))

        ; ========================================
        ; HBM3E Base Die (Logic/Buffer)
        ; ========================================
        ; 역할:
        ;  1. PHY 인터페이스 (DRAM ↔ Host)
        ;  2. 메모리 컨트롤러 인터페이스
        ;  3. TSV 신호 완충 (Buffer)
        ;  4. 전력 관리
        ; 채널: 16개
        ; 버스: 1024-bit

        ; 블록 배치
        ; ┌─────────────────────────────┐
        ; │  [PHY]   [Controller]       │
        ; │  [TSV Buffer]  [Power Mgt]  │
        ; └─────────────────────────────┘

        ; PHY 블록
        dbCreateRect(cv list("M1" "drawing") list(0.5 6.0 4.0 8.0))
        dbCreateText(cv "PHY" list(1.0 7.5) "M1" 0.4 "centerLeft")
        dbCreateText(cv sprintf(nil "DQ[0:%d]" 1023)
            list(1.0 7.0) "M1" 0.3 "centerLeft")

        ; Controller 블록
        dbCreateRect(cv list("M1" "drawing") list(4.5 6.0 8.0 8.0))
        dbCreateText(cv "Controller" list(5.0 7.5) "M1" 0.4 "centerLeft")

        ; TSV Buffer 블록
        dbCreateRect(cv list("M2" "drawing") list(0.5 3.0 8.0 5.0))
        dbCreateText(cv "TSV_Buffer" list(1.0 4.5) "M2" 0.4 "centerLeft")
        dbCreateText(cv sprintf(nil "TSV x %d" 12000)
            list(1.0 4.0) "M2" 0.3 "centerLeft")

        ; Power Management 블록
        dbCreateRect(cv list("M3" "drawing") list(0.5 0.5 8.0 2.5))
        dbCreateText(cv "Power_Mgmt" list(1.0 2.0) "M3" 0.4 "centerLeft")
        dbCreateText(cv sprintf(nil "VDD %.2fV" 0.85)
            list(1.0 1.5) "M3" 0.3 "centerLeft")

        when(cv,
            dbSave(cv)
        )
    )
endprocedure
