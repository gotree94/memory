; ============================================================
; HBM 3D Stack Generator
; Library: hbm_lib
; Cell:    hbm_hbm1_stack
; Auto-generated by HBM Design Automation Tool
; ============================================================

procedure(hbmCreatehbm_hbm1_stack()
    let((cv ws tech
          dieW dieH dieTh
          tsvR tsvPitch tsvCols tsvRows
          chSel chX
          i j k))

        ; ========================================
        ; HBM1 - HBM1 28nm
        ; ========================================
        ; 적층: 4-Hi
        ; 다이 두께: 50μm
        ; TSV: 지름 10μm, 피치 40μm
        ; TSV 수: 5000/다이
        ; 채널: 8개 x 128-bit
        ; 버스: 1024-bit
        ; 대역폭: 128 GB/s
        ; 용량: 1 GB (스택당)
        ; 패키징: 2.5D Silicon Interposer

        ; ┌─────────────────────────────┐
        ; │  Die n (Core)              │
        ; │   ┌───────────────┐        │
        ; │   │ 1T1C Cell     │  TSV   │
        ; │   │ Array         │●●●    │
        ; │   └───────────────┘        │
        ; └─────────────────────────────┘
        ;            ⋮ (N-Hi 적층)
        ; ┌─────────────────────────────┐
        ; │  Base Die (Logic/Buffer)   │
        ; │  PHY + Controller + TSV    │
        ; └─────────────────────────────┘
        ;      ↓ microbump
        ;   [Silicon Interposer]
        ;      ↓ RDL
        ;   [Package Substrate]

        ; ── Core Die 어레이 배치 ──
        dieW = 10.0;  dieH = 8.0
        for(i 0 (4-1)
            ; 다이 영역 (수평 배치로 표현. 실제는 수직 적층)
            dy = i * (dieH + 0.5)
            dbCreateRect(cv list("M1" "drawing")
                list(0.0 dy dieW (+ dy dieH)))

            ; 다이 라벨
            dbCreateText(cv sprintf(nil "Core_Die_%02d" i)
                list(0.5 (+ dy 0.8)) "M1" 0.6 "centerLeft")

            ; TSV 어레이 배치 (모든 다이 공통 위치)
            tsvCols = 50
            for(col 0 tsvCols-1,
                tsvX = 1.0 + col * 0.5
                for(row 0 99,
                    tsvY = dy + 1.5 + row * 0.05
                    ; TSV 원근사 사각형
                    dbCreateCircle(cv list("M3" "drawing")
                        tsvX tsvY 0.01)
                )
            )
        )

        ; ── Base Die (로직) ──
        baseDY = 4 * (dieH + 0.5)
        dbCreateRect(cv list("M4" "drawing")
            list(0.0 baseDY dieW (+ baseDY dieH)))

        dbCreateText(cv "Base_Die (Logic/Buffer)"
            list(0.5 (+ baseDY 0.8)) "M4" 0.6 "centerLeft")
        dbCreateText(cv "PHY"
            list(1.0 (+ baseDY 2.0)) "M4" 0.4 "centerLeft")
        dbCreateText(cv "Controller"
            list(1.0 (+ baseDY 3.0)) "M4" 0.4 "centerLeft")

        ; 채널 분할
        chW = dieW / 8
        for(ch 0 (8-1)
            dbCreateText(cv sprintf(nil "CH%02d_%dbit" ch 128)
                list(+ (* ch chW) 0.5) (+ baseDY 1.0)
                "M4" 0.3 "centerLeft")
        )

        ; ── 패키징 구조 ──
        pkgDY = (4+1) * (dieH + 0.5)
        dbCreateText(cv "2.5D Silicon Interposer"
            list(0.5 (+ pkgDY 2.0)) "M2" 0.5 "centerLeft")
        dbCreateText(cv "TSV x 5000/die"
            list(0.5 (+ pkgDY 2.6)) "M2" 0.3 "centerLeft")
        dbCreateText(cv "Microbump pitch 40μm"
            list(0.5 (+ pkgDY 3.2)) "M2" 0.3 "centerLeft")

        when(cv,
            dbSave(cv)
            println("HBM1 stack layout generated")
        )
    )
endprocedure
