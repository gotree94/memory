; ============================================================
; HBM 3D Stack Generator
; Library: hbm_lib
; Cell:    hbm_hbm2_tsv
; Auto-generated by HBM Design Automation Tool
; ============================================================

procedure(hbmCreatehbm_hbm2_tsv()
    let((cv ws tech
          dieW dieH dieTh
          tsvR tsvPitch tsvCols tsvRows
          chSel chX
          i j k))

        ; ========================================
        ; HBM2 TSV Array
        ; ========================================
        ; TSV 지름: 8μm
        ; TSV 피치: 36μm
        ; TSV 개수: 6000/다이
        ; 다이 두께: 40μm

        ; TSV 좌표 계산
        tsvD = 8
        tsvPitch = 36
        tsvPerRow = 100
        tsvRows = 6000 / tsvPerRow

        ; TSV 배치 (정사각 어레이)
        for(row 0 tsvRows-1,
            for(col 0 tsvPerRow-1,
                x = col * tsvPitch
                y = row * tsvPitch
                ; TSV 홀 생성
                dbCreateCircle(cv list("TSV" "drawing")
                    x y (tsvD / 2))
            )
        )

        ; TSV 신호 분류
        dbCreateText(cv "Signal_TSV" list(1.0 (+ (* tsvRows tsvPitch) 1.0))
            "M3" 0.3 "centerLeft")
        dbCreateText(cv "Power_TSV" list(1.0 (+ (* tsvRows tsvPitch) 2.0))
            "M4" 0.3 "centerLeft")
        dbCreateText(cv "GND_TSV" list(1.0 (+ (* tsvRows tsvPitch) 3.0))
            "M4" 0.3 "centerLeft")

        when(cv,
            dbSave(cv)
        )
    )
endprocedure
